* Extracted by KLayout with SG13G2 LVS runset on : 11/03/2026 20:56

.SUBCKT inverter
M$1 \$2 \$5 \$4 \$1 sg13_lv_nmos L=0.13u W=0.15u AS=0.0655p AD=0.1005p PS=1.9u
+ PD=1.34u
M$2 \$3 \$5 \$4 \$3 sg13_lv_pmos L=0.13u W=0.15u AS=0.1005p AD=0.1005p PS=1.34u
+ PD=1.34u
.ENDS inverter
